.subckt inverter A Q VDD VSS
M1 Q A VDD VDD pmos W=3.3u L=1.0u
.ends inverter
