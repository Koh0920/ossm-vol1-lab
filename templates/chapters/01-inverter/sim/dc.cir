PTC06 CMOS inverter DC transfer
.include /home/ato/.xschem/lib/mos.lib
VDD vdd 0 5
VIN in 0 0
M1 out in vdd vdd pmos W=3.3u L=1.0u
M2 out in 0 0 nmos W=2.0u L=1.0u
CLOAD out 0 10f
.control
set wr_singlescale
set wr_vecnames
dc VIN 0 5 0.05
wrdata /foss/designs/runs/dc.dat v(out)
quit
.endc
.end
